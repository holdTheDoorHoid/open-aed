* NOT FOR CONSTRUCTION — unreviewed design. Simulated results; models as stated; nothing has been built or measured.
* SPDX-License-Identifier: CERN-OHL-S-2.0
*
* held_sensor_rev3.cir — revision 0.3 "held" sensor of each discharge stack (11_hv_storage), two independent
* sensors per stack, each on its own line to 09 (HOLD_x_HELD_N and HOLD_x_HELD2_N). Questions: I-4 (closed by
* duplication, charger-storage/notes.md Q1) and the open "-20 C aged threshold above the hold level" item.
* Changes against held_detector.cir arrangement A (as drawn):
*   zener MMSZ4688 4.7 V -> MMSZ4687 4.3 V (onsemi MMSZ4678T1/D Rev 13: VZ 4.09-4.52 V at IZT 50 uA)
*   sheet-09 pull-up 10 k -> 22 k to 5V0_SYS (needs 0.21 mA of Darlington sink instead of 0.46 mA)
*   series resistor 3.9 k kept; LED shunt 22 k kept.
* Valid only with IXTT2N170D2 stack devices (cut-off magnitude <= 4.0 V x 1.06 = 4.24 V at 70 C, DS100418B as
* read in charger-storage/notes.md): with IXTT10N100D2 (<= 4.77 V) the low corner would have no margin.
* Corners as held_detector.cir: LOW = min zener, low LED VF (IS x3), CTR 10,000 %, +70 C, dark 20 uA;
* NOM = 25 C, CTR 500 %; HIGH = max zener, high LED VF (IS / 3), aged CTR 250 %, -20 C.
* Zener temperature coefficient +-2e-4 /K [EST, as charger-storage], NOT read from the MMSZ4687 datasheet.
* Arrangement R1: one sensor as above (each of the two sensors behaves identically and alone).
* Arrangement R1S: R1 with the zener shorted (shows what the OTHER sensor must still prevent).
* Arrangement A: the drawn sensor for comparison (4.7 V, 10 k pull-up).
.include ../charger-storage/models/datasheet_models.lib
.param bz=4.3 bz47=4.7 tbvz=0 ctrp=5 isl=4.7e-14 idk=0.2u rpu=22k
VG g 0 0
V5 v5 0 5
* ---- R1
VIR r0 0 0
RR1 r0 rzk 3.9k
XZR rla rzk ZENER params: bvz={bz} tbv={tbvz}
RR2 rla g 22k
XOR rla g hr 0 TLP187 params: ctr={ctrp} isled={isl} idark={idk}
RPR v5 hr {rpu}
RBR v5 hr 1meg
* ---- R1S (zener shorted)
RS1 0 szk 3.9k
XZS sla szk ZENER params: bvz={bz} tbv={tbvz}
RZS szk sla 0.1
RS2 sla g 22k
XOS sla g hs 0 TLP187 params: ctr={ctrp} isled={isl} idark={idk}
RPS v5 hs {rpu}
* ---- A as drawn
VIA a0 0 0
RA1 a0 azk 3.9k
XZA ala azk ZENER params: bvz={bz47} tbv={tbvz}
RA2 ala g 22k
XOA ala g ha 0 TLP187 params: ctr={ctrp} isled={isl} idark={idk}
RPA v5 ha 10k
* temperature probe, isolated from the circuit: one BAT54 at 1 mA. Its forward voltage is printed in every result line
* to prove that the corner temperature reached the device models (0.388 V at -20 C, 0.323 V at 27 C, 0.263 V at 70 C).
IPRB 0 tprb 1m
DPRB tprb 0 BAT54
.control
set noaskquit
foreach cn 1 2 3
  if $cn = 1
    set cname = LOW
    alterparam bz = 4.09
    alterparam bz47 = 4.47
    alterparam isl = 1.41e-13
    alterparam ctrp = 100
    alterparam tbvz = -2e-4
    alterparam idk = 20u
    set tc = 70
  end
  if $cn = 2
    set cname = NOM
    alterparam bz = 4.3
    alterparam bz47 = 4.7
    alterparam isl = 4.7e-14
    alterparam ctrp = 5
    alterparam tbvz = 0
    alterparam idk = 0.2u
    set tc = 25
  end
  if $cn = 3
    set cname = HIGH
    alterparam bz = 4.52
    alterparam bz47 = 4.94
    alterparam isl = 1.57e-14
    alterparam ctrp = 2.5
    alterparam tbvz = 2e-4
    alterparam idk = 0.2u
    set tc = -20
  end
  reset
  * temperature AFTER reset (reset returns the circuit to the netlist temperature, 27 C; see the Correction in notes.md)
  option temp=$tc
  dc VG 0 -12 -0.005
  meas dc vprb max v(tprb)
  meas dc thR  find v(g) when v(hr)=1.2 fall=1
  meas dc thRS find v(g) when v(hs)=1.2 fall=1
  meas dc thA  find v(g) when v(ha)=1.2 fall=1
  meas dc hdark find v(hr) at=0
  meas dc iR6  find i(VIR) at=-6.0
  meas dc iR74 find i(VIR) at=-7.4
  meas dc iA74 find i(VIA) at=-7.4
  let l6 = abs(iR6)*1e6
  let l74 = abs(iR74)*1e6
  let la74 = abs(iA74)*1e6
  echo "HELD corner=$cname T=$tc C (probe BAT54 VF at 1 mA = $&vprb V) rev3_threshold=$&thR rev3_zener_shorted=$&thRS drawn_threshold=$&thA | HELD_N_dark=$&hdark V | load_per_sensor_uA at -6.0V=$&l6 at -7.4V=$&l74 (drawn at -7.4V=$&la74)"
end
quit
.endc
.end
