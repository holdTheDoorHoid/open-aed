* NOT FOR CONSTRUCTION — unreviewed design. Simulated results; models as stated; nothing has been built or measured.
* SPDX-License-Identifier: CERN-OHL-S-2.0
*
* stack_shock_wpf.cir — REALISTIC shock-and-recharge sequence (derived from stack_dynamic_wpf.cir): dynamic voltage sharing of stack A as drawn after revision 0.3 (stack_drawn.inc), held
* (bottom gate at the cold hold level -5.9 V through R1194 470 ohm and the 3.3 uF reservoir C1109).
* Events (as charger-storage/stack_dynamic.ctl, so the results compare):
*   0-50 ms slow rise to 1,000 V; 100 ms: 1,000 -> 2,200 V in 1 us (bounding: faster than anything that can reach
*   a held stack); 0.25 s: 2,200 -> 1,200 V in 10 ms (shock-like); 0.45 s: 1,200 -> 2,200 V in 2 ms (bounding).
* Cases: (a) the worst C0G pattern for each position k (string capacitor k AND per-device capacitor k at -5 %, all
* others +5 %), cold and hot; (b) Monte Carlo 40 runs per corner: every 3.3 nF uniform +-5 %, cut-off -2..-4 V,
* leakage 2-100 % of max; (c) one device shorted (each position), worst C0G pattern for the device below it.
* Corners as stack_static_wpf.ctl (Fig. 12 factors; GP02 leakage 0.5 uA cold / 50 uA hot bounding).
.include ../charger-storage/models/datasheet_models.lib
.include models/wpf_models.lib
.include stack_drawn.inc
.param tf=1 leakt=68meg ilk=5u vo1=-3 vo2=-3 vo3=-3 vo4=-3 lk1=0.3 lk2=0.3 lk3=0.3 lk4=0.3
.param cs1=1 cs2=1 cs3=1 cs4=1 cd1=1 cd2=1 cd3=1 cd4=1 sh1=0 sh2=0 sh3=0 sh4=0
* charge 0 -> 2,200 V in 1 s (faster than the charger's >= 3 s: conservative), hold, shock 2,200 -> 1,200 V in 10 ms at
* 1.5 s, hold 0.5 s (analysis), recharge 1,200 -> 2,200 V in 1 s, hold.
VCAP hvp 0 PWL(0 0 1 2200 1.5 2200 1.51 1200 2.0 1200 3.0 2200 3.5 2200)
VH ph 0 -5.9
R1194 ph g1 470
C1109 g1 0 3.3u
R1127 g1 0 1.01meg
XA hvp g1 0 STACKWPF params: tf={tf} leakt={leakt} ilk={ilk} vo1={vo1} vo2={vo2} vo3={vo3} vo4={vo4}
+ lk1={lk1} lk2={lk2} lk3={lk3} lk4={lk4} cs1={cs1} cs2={cs2} cs3={cs3} cs4={cs4} cd1={cd1} cd2={cd2} cd3={cd3}
+ cd4={cd4} sh1={sh1} sh2={sh2} sh3={sh3} sh4={sh4} rm=1
.control
set noaskquit
option reltol=1e-4 method=gear
foreach k 0 1 2 3 4
  foreach tc 1 3
    if $tc = 1
      alterparam tf = 0.89
      alterparam leakt = 262meg
      alterparam ilk = 0.5u
      set tn = cold
      set rat = 1666
    end
    if $tc = 3
      alterparam tf = 1.11
      alterparam leakt = 17.7meg
      alterparam ilk = 50u
      set tn = hot
      set rat = 1700
    end
    alterparam sh1 = 0
    alterparam sh2 = 0
    alterparam sh3 = 0
    alterparam sh4 = 0
    alterparam cs1 = 0.95
    alterparam cd1 = 0.95
    alterparam cs2 = 1.05
    alterparam cd2 = 1.05
    alterparam cs3 = 1.05
    alterparam cd3 = 1.05
    alterparam cs4 = 1.05
    alterparam cd4 = 1.05
    if $k = 1
      alterparam sh1 = 1
    end
    if $k = 2
      alterparam sh2 = 1
    end
    if $k = 3
      alterparam sh3 = 1
    end
    if $k = 4
      alterparam sh4 = 1
    end
    reset
    save v(xa.vdm) v(hvp)
    tran 1u 3.5 0 20u uic
    meas tran a1 max v(xa.vdm) from=0.9 to=1.5
    meas tran a2 max v(xa.vdm) from=1.5 to=2.0
    meas tran a3 max v(xa.vdm) from=2.0 to=3.5
    let cur = max(max(a1,a2),a3)
    let mg = 1 - cur/$rat
    echo "SHOCK shorted_device=$k T=$tn | charged 2200 V: $&a1 | shock 2200->1200 V in 10 ms + 0.5 s: $&a2 | recharge to 2200 V in 1 s + hold: $&a3 | worst=$&cur rating=$rat margin=$&mg"
  end
end
quit
.endc
.end
