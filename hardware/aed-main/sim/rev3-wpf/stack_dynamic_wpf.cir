* NOT FOR CONSTRUCTION — unreviewed design. Simulated results; models as stated; nothing has been built or measured.
* SPDX-License-Identifier: CERN-OHL-S-2.0
*
* stack_dynamic_wpf.cir — DYNAMIC voltage sharing of stack A as drawn after revision 0.3 (stack_drawn.inc), held
* (bottom gate at the cold hold level -5.9 V through R1194 470 ohm and the 3.3 uF reservoir C1109).
* Events (as charger-storage/stack_dynamic.ctl, so the results compare):
*   0-50 ms slow rise to 1,000 V; 100 ms: 1,000 -> 2,200 V in 1 us (bounding: faster than anything that can reach
*   a held stack); 0.25 s: 2,200 -> 1,200 V in 10 ms (shock-like); 0.45 s: 1,200 -> 2,200 V in 2 ms (bounding).
* Cases: (a) the worst C0G pattern for each position k (string capacitor k AND per-device capacitor k at -5 %, all
* others +5 %), cold and hot; (b) Monte Carlo 40 runs per corner: every 3.3 nF uniform +-5 %, cut-off -2..-4 V,
* leakage 2-100 % of max; (c) one device shorted (each position), worst C0G pattern for the device below it.
* Corners as stack_static_wpf.ctl (Fig. 12 factors; GP02 leakage 0.5 uA cold / 50 uA hot bounding).
.include ../charger-storage/models/datasheet_models.lib
.include models/wpf_models.lib
.include stack_drawn.inc
.param tf=1 leakt=68meg ilk=5u vo1=-3 vo2=-3 vo3=-3 vo4=-3 lk1=0.3 lk2=0.3 lk3=0.3 lk4=0.3
.param cs1=1 cs2=1 cs3=1 cs4=1 cd1=1 cd2=1 cd3=1 cd4=1 sh1=0 sh2=0 sh3=0 sh4=0
VCAP hvp 0 PWL(0 0 50m 1000 100m 1000 100.001m 2200 0.25 2200 0.26 1200 0.45 1200 0.452 2200)
VH ph 0 -5.9
R1194 ph g1 470
C1109 g1 0 3.3u
R1127 g1 0 1.01meg
XA hvp g1 0 STACKWPF params: tf={tf} leakt={leakt} ilk={ilk} vo1={vo1} vo2={vo2} vo3={vo3} vo4={vo4}
+ lk1={lk1} lk2={lk2} lk3={lk3} lk4={lk4} cs1={cs1} cs2={cs2} cs3={cs3} cs4={cs4} cd1={cd1} cd2={cd2} cd3={cd3}
+ cd4={cd4} sh1={sh1} sh2={sh2} sh3={sh3} sh4={sh4} rm=1
.include stack_dynamic_wpf.ctl
.end
