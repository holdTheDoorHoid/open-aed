* NOT FOR CONSTRUCTION — unreviewed design. Simulated results; models as stated; nothing has been built or measured.
* SPDX-License-Identifier: CERN-OHL-S-2.0
*
* held_detector.cir — the "held" sensor of each discharge stack (11_hv_storage: R1137 3.9 k, D1125
* MMSZ4688 4.7 V, R1138 22 k across the TLP187 U1101 LED, from HV_RTN to the bottom gate STKA_G; Darlington
* to HOLD_A_HELD_N with 10 k pull-up to 5V0_SYS on sheet 09). Question I-4.
* DC sweep of the bottom-gate voltage (relative to HV_RTN) from 0 to -12 V. "Held" is read when
* HELD_N < 1.2 V (sheet 09 must read with V_IL >= 1.2 V: WP-F C-9). The script reports the gate magnitude
* at which each arrangement starts to read "held" (its threshold) and the current it draws from the pump.
* (zener subcircuit pins are anode, cathode: cathode toward HV_RTN)
* Arrangements on the same swept gate (each is independent of the others):
*   A  as drawn: 3.9 k + 4.7 V zener + LED||22 k
*   AS as drawn, zener SHORTED          AO as drawn, zener OPEN
*   B  PROPOSAL 1: two 3.9 V zeners (MMSZ4686) in series, 3.9 k, LED||22 k   (needs a stronger pump)
*   BS proposal 1 with ONE zener shorted
*   C  PROPOSAL 2: two complete as-drawn strings (own zener, own opto); the two Darlingtons in SERIES
*      to the one HELD_N line (AND): "held" only if both LEDs are lit
*   CS proposal 2 with one string's zener shorted
* Models: models/datasheet_models.lib (hand-built; MMSZ4686 range 3.7-4.1 V at 50 uA from the onsemi
* MMSZ4678 series datasheet as recalled, NOT re-read [UNVERIFIED]).
.include models/datasheet_models.lib
.param bz47=4.7 bz39=3.9 tbvz=0 ctrp=5 isl=4.7e-14 idk=0.2u

VG g 0 0
V5 v5 0 5

* ---- A: as drawn
VIA a0 0 0
RA1 a0 azk 3.9k
XZA ala azk ZENER params: bvz={bz47} tbv={tbvz}
RA2 ala g 22k
XOA ala g ha 0 TLP187 params: ctr={ctrp} isled={isl} idark={idk}
RPA v5 ha 10k
* ---- AS: zener shorted
VIAS as0 0 0
RAS1 as0 aszk 3.9k
XZAS asla aszk ZENER params: bvz={bz47} tbv={tbvz}
RZAS aszk asla 0.1
RAS2 asla g 22k
XOAS asla g has 0 TLP187 params: ctr={ctrp} isled={isl} idark={idk}
RPAS v5 has 10k
* ---- AO: zener open (1 Gohm)
RAO1 0 aozk 3.9k
RZAO aozk aola 1g
RAO2 aola g 22k
XOAO aola g hao 0 TLP187 params: ctr={ctrp} isled={isl} idark={idk}
RPAO v5 hao 10k
* ---- B: two 3.9 V zeners in series
VIB b0 0 0
RB1 b0 bz1 3.9k
XZB1 bz2 bz1 ZENER params: bvz={bz39} tbv={tbvz}
XZB2 bla bz2 ZENER params: bvz={bz39} tbv={tbvz}
RB2 bla g 22k
XOB bla g hb 0 TLP187 params: ctr={ctrp} isled={isl} idark={idk}
RPB v5 hb 10k
* ---- BS: one of the two shorted
RBS1 0 bsz1 3.9k
XZBS1 bsz2 bsz1 ZENER params: bvz={bz39} tbv={tbvz}
RZBS bsz1 bsz2 0.1
XZBS2 bsla bsz2 ZENER params: bvz={bz39} tbv={tbvz}
RBS2 bsla g 22k
XOBS bsla g hbs 0 TLP187 params: ctr={ctrp} isled={isl} idark={idk}
RPBS v5 hbs 10k
* ---- C: two complete strings, Darlingtons in series (AND)
VIC c0 0 0
RC1 c0 czk 3.9k
XZC1 cla czk ZENER params: bvz={bz47} tbv={tbvz}
RC2 cla g 22k
XOC1 cla g hc cmid TLP187 params: ctr={ctrp} isled={isl} idark={idk}
RC3 c0 czk2 3.9k
XZC2 cla2 czk2 ZENER params: bvz={bz47} tbv={tbvz}
RC4 cla2 g 22k
XOC2 cla2 g cmid 0 TLP187 params: ctr={ctrp} isled={isl} idark={idk}
RPC v5 hc 10k
* ---- CS: as C, first string's zener shorted
RCS1 0 cszk 3.9k
XZCS1 csla cszk ZENER params: bvz={bz47} tbv={tbvz}
RZCS cszk csla 0.1
RCS2 csla g 22k
XOCS1 csla g hcs csmid TLP187 params: ctr={ctrp} isled={isl} idark={idk}
RCS3 0 cszk2 3.9k
XZCS2 csla2 cszk2 ZENER params: bvz={bz47} tbv={tbvz}
RCS4 csla2 g 22k
XOCS2 csla2 g csmid 0 TLP187 params: ctr={ctrp} isled={isl} idark={idk}
RPCS v5 hcs 10k

* temperature probe, isolated from the circuit: one BAT54 at 1 mA. Its forward voltage is printed in every result line
* to prove that the corner temperature reached the device models (0.388 V at -20 C, 0.323 V at 27 C, 0.263 V at 70 C).
IPRB 0 tprb 1m
DPRB tprb 0 BAT54
.control
set noaskquit
echo "HELD threshold = |gate| (V) where HELD_N falls through 1.2 V; load = pump current (uA) at the gate level shown"
* corners: low threshold = min zener, low LED VF (IS x3), max CTR (100 = 10,000 %), hot (+70 C)
*          high threshold = max zener, high LED VF (IS / 3), aged CTR (2.5 = 250 %), cold (-20 C)
*          nominal = 25 C, CTR 500 %
foreach cn 1 2 3
  if $cn = 1
    set cname = LOW
    alterparam bz47 = 4.47
    alterparam bz39 = 3.7
    alterparam isl = 1.41e-13
    alterparam ctrp = 100
    alterparam tbvz = -2e-4
    alterparam idk = 20u
    set tc = 70
  end
  if $cn = 2
    set cname = NOM
    alterparam bz47 = 4.7
    alterparam bz39 = 3.9
    alterparam isl = 4.7e-14
    alterparam ctrp = 5
    alterparam tbvz = 0
    alterparam idk = 0.2u
    set tc = 25
  end
  if $cn = 3
    set cname = HIGH
    alterparam bz47 = 4.94
    alterparam bz39 = 4.1
    alterparam isl = 1.57e-14
    alterparam ctrp = 2.5
    alterparam tbvz = 2e-4
    alterparam idk = 0.2u
    set tc = -20
  end
  reset
  * temperature AFTER reset (reset returns the circuit to the netlist temperature, 27 C; see the Correction in notes.md)
  option temp=$tc
  dc VG 0 -12 -0.005
  meas dc vprb max v(tprb)
  meas dc thA  find v(g) when v(ha)=1.2 fall=1
  meas dc thAS find v(g) when v(has)=1.2 fall=1
  meas dc thB  find v(g) when v(hb)=1.2 fall=1
  meas dc thBS find v(g) when v(hbs)=1.2 fall=1
  meas dc thC  find v(g) when v(hc)=1.2 fall=1
  meas dc thCS find v(g) when v(hcs)=1.2 fall=1
  meas dc hAO  min v(hao)
  meas dc iA74 find i(VIA) at=-7.4
  meas dc iB74 find i(VIB) at=-7.4
  meas dc iC74 find i(VIC) at=-7.4
  meas dc iB105 find i(VIB) at=-10.5
  meas dc lowC min v(hc)
  echo "HELD corner=$cname T=$tc C (probe BAT54 VF at 1 mA = $&vprb V) A_drawn=$&thA A_zener_short=$&thAS A_zener_open_minHELDN=$&hAO B_2x3V9=$&thB B_one_short=$&thBS C_dual_AND=$&thC C_one_short=$&thCS"
  let la = abs(iA74)*1e6
  let lb = abs(iB74)*1e6
  let lc = abs(iC74)*1e6
  let lb2 = abs(iB105)*1e6
  echo "LOAD corner=$cname A_at_7V4_uA=$&la B_at_7V4_uA=$&lb B_at_10V5_uA=$&lb2 C_at_7V4_uA=$&lc C_lowest_HELDN_V=$&lowC"
end
quit
.endc
.end
