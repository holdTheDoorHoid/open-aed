* NOT FOR CONSTRUCTION — unreviewed design. Simulated results; models as stated; nothing has been built or measured.
* SPDX-License-Identifier: CERN-OHL-S-2.0
*
* discharge.cir — emptying the 100 uF storage capacitor through the default-on discharge paths
* (11_hv_storage). Question 2: time from 2,200 V to under 60 V through one path and through both; peak power
* and energy in the dump resistors (R1101..R1106, Ohmite EY152KE 1.5 k 10 %) and in the stack transistors,
* for a normal release and for a release circuit that has failed (bottom gate decays only through
* R1127+R1128 1.01 Mohm from the 3.3 uF reservoir, tau ~3.3 s).
* Each path: 3 x 1.5 k in series with a 4-device stack, drawn topology (100 k tap feed, 10 Mohm gate-source,
* SMF15CA gate TVS, 4 x 10 Mohm sharing string with 3.3 nF). Everything always connected is included: the
* bleeder 19.92 Mohm, two sense strings (40.24 / 39.84 Mohm).
* The bottom gate of each path is a behavioural source: held at -7.4 V until trel, then rising towards 0 V
* with time constant taug (normal release: 20 us = BSS138 ~5 ohm x 3.3 uF [EST]; failed release: 3.33 s).
* Models: models/datasheet_models.lib (hand-built). The EY resistor TCR -1,200 ppm/K [DS as read in WP-F]
* is applied through rmult (cold +5.4 %, hot -5.4 %, plus the 10 % tolerance); no self-heating is modelled.
.include models/datasheet_models.lib
.param vc0=2200 cap=100u rmult=1.0 pathb=1 taug=20u trel=1m dev=1
.param kpd={dev==1 ? 4 : 0.6} rdd={dev==1 ? 1.4 : 6.0} cgsd={dev==1 ? 5.25n : 3.57n}
.param cgdd={dev==1 ? 424p : 485p} cdsd={dev==1 ? 1.39n : 760p} voffd={dev==1 ? -3.5 : -3.0}

.subckt STACK4 hvp rtn gb params: rm=1 kp=4 rd=1.4 cgs=5.25n cgd0=424p cds0=1.39n vo=-3.5
RD1 hvp d1 {1.5k*rm}
RD2 d1 d2 {1.5k*rm}
RD3 d2 top {1.5k*rm}
X1 m1 gb rtn DEPMOS params: voff={vo} rleak=300meg kp={kp} rd={rd} cgs={cgs} cgd0={cgd0} cds0={cds0}
XT1 gb rtn SMF15CA
X2 m2 g2 m1 DEPMOS params: voff={vo} rleak=300meg kp={kp} rd={rd} cgs={cgs} cgd0={cgd0} cds0={cds0}
RG2 t1 g2 100k
RGS2 g2 m1 10meg
XT2 g2 m1 SMF15CA
X3 m3 g3 m2 DEPMOS params: voff={vo} rleak=300meg kp={kp} rd={rd} cgs={cgs} cgd0={cgd0} cds0={cds0}
RG3 t2 g3 100k
RGS3 g3 m2 10meg
XT3 g3 m2 SMF15CA
X4 top g4 m3 DEPMOS params: voff={vo} rleak=300meg kp={kp} rd={rd} cgs={cgs} cgd0={cgd0} cds0={cds0}
RG4 t3 g4 100k
RGS4 g4 m3 10meg
XT4 g4 m3 SMF15CA
RS1 t1 rtn 10meg
RS2 t2 t1 10meg
RS3 t3 t2 10meg
RS4 top t3 10meg
CS1 t1 rtn 3.3n
CS2 t2 t1 3.3n
CS3 t3 t2 3.3n
CS4 top t3 3.3n
* per-device power (W) using the device current = dump-resistor current
BP1 p1 rtn V=v(m1,rtn)*v(hvp,top)/(4.5k*{rm})
BP2 p2 rtn V=v(m2,m1)*v(hvp,top)/(4.5k*{rm})
BP3 p3 rtn V=v(m3,m2)*v(hvp,top)/(4.5k*{rm})
BP4 p4 rtn V=v(top,m3)*v(hvp,top)/(4.5k*{rm})
BPR pr rtn V=(v(hvp,top)/3)^2/(1.5k*{rm})
BV1 vd1 rtn V=v(m1,rtn)
BV2 vd2 rtn V=v(m2,m1)
BV3 vd3 rtn V=v(m3,m2)
BV4 vd4 rtn V=v(top,m3)
.ends STACK4

C1101 hvp 0 {cap} ic={vc0}
* always-connected loads
RBLEED hvp 0 19.92meg
RSM hvp 0 40.24meg
RSS hvp 0 39.84meg
* path A (always released at trel) and path B (released too when pathb = 1, else held at -7.4 V)
BGA ga 0 V={ time < trel ? -7.4 : -7.4*exp(-(time-trel)/taug) }
BGB gbb 0 V={ (pathb > 0.5 && time >= trel) ? -7.4*exp(-(time-trel)/taug) : -7.4 }
XA hvp 0 ga STACK4 params: rm={rmult} kp={kpd} rd={rdd} cgs={cgsd} cgd0={cgdd} cds0={cdsd} vo={voffd}
XB hvp 0 gbb STACK4 params: rm={rmult} kp={kpd} rd={rdd} cgs={cgsd} cgd0={cgdd} cds0={cdsd} vo={voffd}
BIA ia 0 V=v(hvp,xa.top)/(4.5k*{rmult})

.control
set noaskquit
* cases: name pathb taug rmult cap
foreach cs 1 2 3 4 5 6 7 8
  alterparam dev = 1
  if $cs = 1
    set nm = "one_path_nominal"
    alterparam pathb = 0
    alterparam taug = 20u
    alterparam rmult = 1.0
    alterparam cap = 100u
    set tend = 4
  end
  if $cs = 2
    set nm = "one_path_slowest(R+10%,cold+5.4%,C+5%)"
    alterparam rmult = 1.159
    alterparam cap = 105u
    set tend = 5
  end
  if $cs = 3
    set nm = "one_path_fastest(R-10%,hot-5.4%,C-5%)"
    alterparam rmult = 0.851
    alterparam cap = 95u
    set tend = 4
  end
  if $cs = 4
    set nm = "both_paths_nominal"
    alterparam pathb = 1
    alterparam rmult = 1.0
    alterparam cap = 100u
    set tend = 3
  end
  if $cs = 5
    set nm = "both_paths_slowest"
    alterparam rmult = 1.159
    alterparam cap = 105u
    set tend = 3
  end
  if $cs = 6
    set nm = "one_path_RELEASE_FAILED(1.01M_x_3.3uF)"
    alterparam pathb = 0
    alterparam taug = 3.33
    alterparam rmult = 1.0
    alterparam cap = 100u
    set tend = 9
  end
  if $cs = 7
    set nm = "one_path_nominal_IXTT2N170D2"
    alterparam dev = 2
    alterparam taug = 20u
    set tend = 4
  end
  if $cs = 8
    set nm = "one_path_RELEASE_FAILED_IXTT2N170D2"
    alterparam dev = 2
    alterparam taug = 3.33
    set tend = 9
  end
  reset
  tran 2u $tend 0 2m uic
  meas tran t60 when v(hvp)=60 fall=1
  meas tran ipk max v(ia)
  meas tran ppr max v(xa.pr)
  meas tran epr integ v(xa.pr)
  meas tran pd1 max v(xa.p1)
  meas tran pd2 max v(xa.p2)
  meas tran pd3 max v(xa.p3)
  meas tran pd4 max v(xa.p4)
  meas tran ed1 integ v(xa.p1)
  meas tran ed2 integ v(xa.p2)
  meas tran ed3 integ v(xa.p3)
  meas tran ed4 integ v(xa.p4)
  meas tran vd1 max v(xa.vd1) from=0.9m to=50m
  meas tran vd2 max v(xa.vd2) from=0.9m to=50m
  meas tran vd3 max v(xa.vd3) from=0.9m to=50m
  meas tran vd4 max v(xa.vd4) from=0.9m to=50m
  let vdmax = max(max(vd1,vd2),max(vd3,vd4))
  let pdmax = max(max(pd1,pd2),max(pd3,pd4))
  let edmax = max(max(ed1,ed2),max(ed3,ed4))
  let t60r = t60 - 1m
  echo "DUMP $nm | t_to_60V_s=$&t60r peak_A_per_path=$&ipk | resistor: peak_W=$&ppr energy_J=$&epr | worst device: peak_W=$&pdmax energy_J=$&edmax | max Vds of any device in the first 50 ms=$&vdmax V"
end
quit
.endc
.end
