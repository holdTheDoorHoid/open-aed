* NOT FOR CONSTRUCTION — unreviewed design. Simulated results; models as stated; nothing has been built or measured.
* SPDX-License-Identifier: CERN-OHL-S-2.0
*
* hold_pump.cir — hold pump, release circuit and "held" sensor of stack A (11_hv_storage; stack B is
* identical). Questions I-17 (hold/release timing at the slowest clock and -20 C) and I-24 (stage count).
* Circuit as drawn: HOLD_A_DRV (clock, source resistance rclk) -> R1133 10 ohm -> PMPA_CLK; R1131 100 k to GND;
* single-clock Dickson-type pump: pump capacitors C1111..C1114 (cpump) from the clock to P1..P4; BAT54S pairs
* D1109..D1112 (H_k -> P_k -> H_k-1, H_0 = HV_RTN); hold capacitors C1115..C1117 (chold) H1..H3 to HV_RTN;
* H4 = bottom gate STKA_G with reservoir C1109 3.3 uF, R1127+R1128 1.01 Mohm, SMF15CA D1101, bottom-device
* gate capacitance (Ciss), OVP opto U1103 dark current (idarkovp).
* Release: pilot JFET Q1112 MMBFJ177 (S HV_RTN, D RLSA_NG, G RLSA_JB), BSS138 Q1109 (D HV_RTN, S STKA_G, G
* RLSA_NG), R1188 1 M; positive pilot pump C1125..C1127 10 nF, BAV199 D1117..D1119, C1128/C1129 4.7 nF with
* R1190/R1191 2.2 M, C1130 2.2 nF with R1135 1.8 M.
* Held sensor: as drawn (string A). Option nsens=2 adds a second identical string (proposal for I-4).
* Stage count is a parameter: nstg = 3 (contract), 4 (as drawn), 5 (proposal). Stages above nstg are inert.
* HV_RTN is node 0 here (everything on this sub-circuit is referenced to the stack source).
* Models: models/datasheet_models.lib (hand-built). WP-F's corners: capacitors derated to 70 % (X7R DC bias,
* temperature) at the hot and cold corners [EST]; clock source 30-40 ohm [WP-F].
.include models/datasheet_models.lib
.param nstg=4 cpump=2.2u chold=2.2u cres=3.3u kcap=1.0 vclk=3.3 fclk=2k rclk=35 tstop=150m trestart=190m
.param stophigh=0 vp=1.5 ciss=5.3n nsens=1 ctrp=5 isl=4.7e-14 bz=4.7 idarkovp=0.2u cjb=2.2n rjb=1.8meg npil=3 tgap=100m gap=1m cin=4.7n rpb=1e12 rpo=1m
.param tper={1/fclk}

* ---- clock, stopped at tstop (low, or high if stophigh=1), restarted at trestart
VCK ck0 0 PULSE(0 {vclk} 0 2u 2u {tper/2-2u} {tper})
BCK ck1 0 V={ ((time<tstop && (time<tgap || time>tgap+gap)) || time>trestart) ? v(ck0) : stophigh*vclk }
RCK ck1 drv {rclk}
R1131 drv 0 100k
R1133 drv clk 10
* ---- negative pump, stage k: Cp clk->P_k ; D H_k->P_k ; D P_k->H_k-1 ; Ch H_k->0
CP1 clk p1 {kcap*cpump*(1<=nstg ? 1 : 1e-6)}
CP2 clk p2 {kcap*cpump*(2<=nstg ? 1 : 1e-6)}
CP3 clk p3 {kcap*cpump*(3<=nstg ? 1 : 1e-6)}
CP4 clk p4 {kcap*cpump*(4<=nstg ? 1 : 1e-6)}
CP5 clk p5 {kcap*cpump*(5<=nstg ? 1 : 1e-6)}
DA1 h1 p1 BAT54
DB1 p1 0 BAT54
DA2 h2 p2 BAT54
DB2 p2 h1 BAT54
DA3 h3 p3 BAT54
DB3 p3 h2 BAT54
DA4 h4 p4 BAT54
DB4 p4 h3 BAT54
DA5 h5 p5 BAT54
DB5 p5 h4 BAT54
CH1 h1 0 {kcap*chold*(1<nstg ? 1 : 1e-6)}
CH2 h2 0 {kcap*chold*(2<nstg ? 1 : 1e-6)}
CH3 h3 0 {kcap*chold*(3<nstg ? 1 : 1e-6)}
CH4 h4 0 {kcap*chold*(4<nstg ? 1 : 1e-6)}
CH5 h5 0 1p
* the last stage output is the bottom gate g (rpo: optional series resistor, 4-stage only; proposal)
RJ3 h3 g {nstg==3 ? 1m : 1e12}
RJ4 h4 g {nstg==4 ? rpo : 1e12}
RJ5 h5 g {nstg==5 ? 1m : 1e12}
* ---- bottom gate node STKA_G
C1109 g 0 {kcap*cres}
CISS g 0 {ciss}
R1127 g gtp 680k
R1128 gtp 0 330k
XD1101 g 0 SMF15CA
* OVP opto U1103 (collector HV_RTN, emitter STKA_G): dark current only (LED off)
GOVP 0 g cur={idarkovp}*(1-exp(-max(-v(g),0)/0.1))
* ---- release: pilot JFET + BSS138
XQ1112 rng jb 0 J177 params: vp={vp}
M1109 0 rng g g BSS138
R1188 rng g 1meg
C1125 clk rp1 10n
C1126 clk rp2 10n
C1127 clk rp3 10n
* optional bleed resistors on the pilot-pump nodes RLSA_P1..P3 (proposal; rpb = 1e12 means absent)
RPB1 rp1 0 {rpb}
RPB2 rp2 0 {rpb}
RPB3 rp3 0 {rpb}
DR1a 0 rp1 BAV199
DR1b rp1 rh1 BAV199
DR2a rh1 rp2 BAV199
DR2b rp2 rh2 BAV199
DR3a rh2 rp3 BAV199
DR3b rp3 rh3 BAV199
* optional 4th pilot stage (npil = 4, proposal); with npil = 3 rh3 is joined to jb
C1127x rh3 0 {npil==4 ? cin : 1p}
R1191x rh3 0 {npil==4 ? 2.2meg : 1e12}
RJP3 rh3 jb {npil==3 ? 1m : 1e12}
C1127b clk rp4 {npil==4 ? 10n : 1p}
DR4a rh3 rp4 BAV199
DR4b rp4 jb BAV199
C1128 rh1 0 {cin}
R1190 rh1 0 2.2meg
C1129 rh2 0 {cin}
R1191 rh2 0 2.2meg
C1130 jb 0 {cjb}
R1135 jb 0 {rjb}
* ---- held sensor string(s): HV_RTN - 3.9 k - zener (cathode HV_RTN side) - LED || 22 k - STKA_G
VIS1 s1 0 0
R1137 s1 zk 3.9k
XD1125 la zk ZENER params: bvz={bz}
R1138 la g 22k
XU1101 la g heldn 5vgnd TLP187 params: ctr={ctrp} isled={isl}
* sheet 09 pull-up 10 k to 5V0_SYS; the opto emitter is on GND (galvanically separate; modelled as node 0 via 0 V)
V5 v5 0 5
VGE 5vgnd 0 0
RPU v5 heldn 10k
* second string (proposal), present only when nsens = 2 (else its series resistor is huge)
R1137b 0 zkb {nsens==2 ? 3.9k : 1e12}
XD1125b lab zkb ZENER params: bvz={bz}
R1138b lab g 22k
XU1101b lab g heldnb 5vgnd TLP187 params: ctr={ctrp} isled={isl}
* line capacitance of each HELD_N line (LVC input + trace, 47 pF [EST], added 2026-11-28): without it the opto's
* current-source output node has no capacitance and one run aborted with "timestep too small"
CHN heldn 0 47p
CHNb heldnb 0 47p
RPUb v5 heldnb 10k
* the reading the interlock acts on: with two sensors, "held" only if BOTH lines are low
BHA heldall 0 V={nsens==2 ? max(v(heldn),v(heldnb)) : v(heldn)}

* temperature probe, isolated from the circuit: one BAT54 at 1 mA. Its forward voltage is printed in every result line
* to prove that the corner temperature reached the device models (0.388 V at -20 C, 0.323 V at 27 C, 0.263 V at 70 C).
IPRB 0 tprb 1m
DPRB tprb 0 BAT54
.control
set noaskquit
* Timeline (corrected 2026-11-28, see notes.md Correction): clock starts at 0 (all capacitors empty: power-up); the
* hold is judged in 70-100 ms, after start-up has settled (the first version judged it in 30-40 ms, while the cold
* pump was still starting); a 1 ms gap in the clock at 100 ms (the firmware's allowed gap, R-11) must NOT release;
* clock stops at 150 ms (release); restarts at 190 ms (re-hold); run ends at 230 ms.
* "conducting" = gate above -2.33 V (smallest cut-off, IXTT10N100D2 cold, WP-F) or -1.86 V (IXTT2N170D2 cold).
* Case codes: D = as drawn (4-stage pump, 2.2 uF, 3-stage pilot pump, one sensor); C = contract 3-stage pump;
* V = candidate changes: a pilot JFET with a lower maximum pinch-off (2.0, 1.8 V; minimum 1.2 V); 1 Mohm bleeds on
* the pilot-pump nodes RLSA_P1..P3 so a clock stopped HIGH releases like one stopped low; two sensors.
* F = 5-stage pump, one sensor.
foreach cs 1 2 3 4 5 6 7 8 9 10 11 12 13 14 15
  * defaults for every case (cold, slowest clock, derated capacitors), then the case's changes
  alterparam nstg = 4
  alterparam cpump = 2.2u
  alterparam chold = 2.2u
  alterparam kcap = 0.7
  alterparam vclk = 3.1
  alterparam fclk = 1k
  alterparam rclk = 40
  alterparam vp = 2.5
  alterparam nsens = 1
  alterparam npil = 3
  alterparam stophigh = 0
  alterparam cin = 4.7n
  alterparam rjb = 1.8meg
  alterparam rpb = 1e12
  alterparam rpo = 1m
  set tc = -20
  if $cs = 1
    set nm = "D1_drawn_cold_1kHz_3V1_pilot2V5"
  end
  if $cs = 2
    set nm = "D2_drawn_cold_1kHz_3V1_pilot1V5"
    alterparam vp = 1.5
  end
  if $cs = 3
    set nm = "D3_drawn_cold_1kHz_3V1_pilot0V8"
    alterparam vp = 0.8
  end
  if $cs = 4
    set nm = "D4_drawn_25C_2kHz_3V3_pilot1V5"
    alterparam kcap = 1.0
    alterparam vclk = 3.3
    alterparam fclk = 2k
    alterparam rclk = 35
    alterparam vp = 1.5
    set tc = 25
  end
  if $cs = 5
    set nm = "D5_drawn_hot70_1kHz_3V2_pilot1V5_stopHIGH"
    alterparam vclk = 3.2
    alterparam vp = 1.5
    alterparam stophigh = 1
    set tc = 70
  end
  if $cs = 6
    set nm = "D6_drawn_fresh_3V5_2kHz_pilot0V8_stopHIGH"
    alterparam kcap = 1.0
    alterparam vclk = 3.5
    alterparam fclk = 2k
    alterparam rclk = 30
    alterparam vp = 0.8
    alterparam stophigh = 1
    set tc = 25
  end
  if $cs = 7
    set nm = "C1_contract3stg_cold_1kHz_3V1_pilot1V5"
    alterparam nstg = 3
    alterparam vp = 1.5
  end
  if $cs = 8
    set nm = "C2_contract3stg_25C_2kHz_3V3_pilot1V5"
    alterparam nstg = 3
    alterparam kcap = 1.0
    alterparam vclk = 3.3
    alterparam fclk = 2k
    alterparam rclk = 35
    alterparam vp = 1.5
    set tc = 25
  end
  if $cs = 9
    set nm = "F1_5stg_cold_1kHz_3V1_pilot1V5"
    alterparam nstg = 5
    alterparam vp = 1.5
  end
  if $cs = 10
    set nm = "V1_drawn_cold_1kHz_3V1_pilot2V0"
    alterparam vp = 2.0
  end
  if $cs = 11
    set nm = "V2_drawn_cold_1kHz_3V1_pilot1V8"
    alterparam vp = 1.8
  end
  if $cs = 12
    set nm = "V3_Pbleed_fresh_3V5_2kHz_pilot1V2_stopHIGH"
    alterparam rpb = 1meg
    alterparam kcap = 1.0
    alterparam vclk = 3.5
    alterparam fclk = 2k
    alterparam rclk = 30
    alterparam vp = 1.2
    alterparam stophigh = 1
    set tc = 25
  end
  if $cs = 13
    set nm = "V4_Pbleed_hot70_1kHz_3V2_pilot1V2_stopHIGH"
    alterparam rpb = 1meg
    alterparam vclk = 3.2
    alterparam vp = 1.2
    alterparam stophigh = 1
    set tc = 70
  end
  if $cs = 14
    set nm = "V5_Pbleed_cold_1kHz_3V1_pilot1V8"
    alterparam rpb = 1meg
    alterparam vp = 1.8
  end
  if $cs = 15
    set nm = "V6_Pbleed_cold_1kHz_3V1_pilot1V8_DUALSENSOR"
    alterparam rpb = 1meg
    alterparam vp = 1.8
    alterparam nsens = 2
  end
  reset
  * temperature AFTER reset (reset returns the circuit to the netlist temperature, 27 C; see the Correction in notes.md)
  option temp=$tc
  tran 5u 230m 0 20u uic
  * a run the simulator aborted is flagged in the result line instead of being read as \"never released\"
  let tend = time[length(time)-1]
  set runst = complete
  if tend < 229.9m
    set runst = ABORTED_RESULT_VOID
  end
  * defaults so that a measurement that never happens prints as -1 (= did not happen in the run)
  let thm = -1
  let tr23 = -1
  let tr19 = -1
  let tnhm = -1
  let trhm = -1
  meas tran theld  when v(heldall)=1.2 fall=1
  meas tran vprb find v(tprb) at=1m
  meas tran vhmax  max v(g) from=70m to=100m
  meas tran vhmin  min v(g) from=70m to=100m
  meas tran jbmin  min v(jb) from=70m to=100m
  meas tran gapg   max v(g) from=100m to=105m
  meas tran gaph   max v(heldall) from=100.5m to=105m
  meas tran trel23 when v(g)=-2.33 rise=1 td=150m
  meas tran trel19 when v(g)=-1.86 rise=1 td=150m
  meas tran tnh    when v(heldall)=1.2 rise=1 td=150m
  meas tran trh    when v(heldall)=1.2 fall=1 td=190m
  if length(theld) > 0
    let thm = theld*1e3
  end
  if length(trel23) > 0
    let tr23 = (trel23 - 150m)*1e3
  end
  if length(trel19) > 0
    let tr19 = (trel19 - 150m)*1e3
  end
  if length(tnh) > 0
    let tnhm = (tnh - 150m)*1e3
  end
  if length(trh) > 0
    let trhm = (trh - 190m)*1e3
  end
  let rip = vhmax - vhmin
  echo "PUMP $nm run=$runst T=$tc C (probe BAT54 VF at 1 mA = $&vprb V) | held_after_powerup_ms=$&thm hold_worst_V=$&vhmax ripple_V=$&rip pilot_bias_min_V=$&jbmin | 1ms_gap: gate_max=$&gapg heldN_max=$&gaph | stop: gate>-2.33V_ms=$&tr23 gate>-1.86V_ms=$&tr19 not_held_ms=$&tnhm | restart: held_ms=$&trhm"
end
quit
.endc
.end
